* Qucs 26.1.0  C:/Users/larsd/Documents/school/kul 1ste/kul_3de/Masterthesis/Qucs/Miniaturazed_Two_Stage_Transmitter.sch
.INCLUDE "C:/Program Files/Qucs-S/share/qucs-s/xspice_cmlib/include/ngspice_mathfunc.inc"
.INCLUDE "C:/Users/larsd/Documents/school/kul 1ste/kul_3de/Masterthesis/KiCad/Miniaturazed_Two_Stage_transmitter/telemetry_spice_models.lib"
.INCLUDE "C:/Users/larsd/Documents/school/kul 1ste/kul_3de/Masterthesis/KiCad/Miniaturazed_Two_Stage_transmitter/PDTA114EU.lib"
QT1 _net3 Base _net1 QMOD_T1 AREA=1.0
.MODEL QMOD_T1 npn (Is=1E-16 Nf=1 Nr=1 Ikf=0 Ikr=0 Vaf=0 Var=0 Ise=0 Ne=1.5 Isc=0 Nc=2 Bf=100 Br=1 Rbm=0 Irb=0 Rc=0 Re=0 Rb=0 Cje=0 Vje=0.75 Mje=0.33 Cjc=0 Vjc=0.75 Mjc=0.33 Xcjc=1.0 Cjs=0 Vjs=0.75 Mjs=0 Fc=0.5 Tf=0.0 Xtf=0.0 Vtf=0.0 Itf=0.0 Tr=0.0 Kf=0.0 Af=1.0 Ptf=0.0 Xtb=0.0 Xti=3.0 Eg=1.11 Tnom=26.85 )
V1 _net2 0 DC 3
C2 0 _net2  220N
C1 0 RC  580N
R1 RC _net2  2.2MEG tc1=0.0 tc2=0.0
R2 RC Base  15K tc1=0.0 tc2=0.0
L1 _net2 _net0  100N
L2 _net3 _net0  1U
L3 _net0 Out  100N
R3 0 _net1  50 tc1=0.0 tc2=0.0
C5 0 Out  2.2P
C4 _net3 Out  3.3P
C3 _net3 _net0  15P
XX1  Base _net3 XTAL_49M5
XX2  Base Base RC PDTA114EU_FULL

.control

tran 2.0004e-11 1e-07 0
write spice4qucs.tr1.plot v(Base) v(Out) v(RC)
destroy all
reset

exit
.endc
.END
